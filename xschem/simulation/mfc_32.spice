** sch_path: /home/ttuser/Mfcs/mfc_32/xschem/mfc_32.sch
.subckt mfc_32 gate sbd
*.PININFO gate:I sbd:O
XM2 sbd gate sbd sbd sky130_fd_pr__nfet_01v8 L=1.2 W=1.68 nf=1 m=1
.ends
.end
